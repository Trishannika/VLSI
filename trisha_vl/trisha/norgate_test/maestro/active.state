ADE simulation setup
Test trisha_norgate_test_1: trisha/norgate_test/schematic, simulator spectre
  Models: /home/cadence/tech/gpdk045_v_6_0/gpdk045/../models/spectre/gpdk045.scs[mc]
  Temperature: 27
  Analysis tran: stop=200n
  Analysis dc: sweep /V0.dc start=0 stop=1.8 (saves the operating point)
  Signals: /a, /vout, /b
Run mode: Single Run, Sweeps and Corners
