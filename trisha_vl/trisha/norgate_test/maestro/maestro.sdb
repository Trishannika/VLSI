ADE simulation setup
Run mode: Single Run, Sweeps and Corners
Tests:
  trisha_norgate_test_1: trisha/norgate_test/schematic, simulator spectre
