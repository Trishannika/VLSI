ADE simulation setup
Test trisha_norgate_tri_1: trisha/norgate_tri/schematic, simulator spectre
  Models: /home/cadence/tech/gpdk045_v_6_0/gpdk045/../models/spectre/gpdk045.scs[mc]
  Temperature: 27
  Analysis tran: stop=200n
  Analysis dc: sweep /V0.dc start=0 stop=1.8 (saves the operating point)
  Signals: /a, /b, /vout
Run mode: Single Run, Sweeps and Corners
