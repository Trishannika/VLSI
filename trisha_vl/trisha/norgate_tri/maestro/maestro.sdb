ADE simulation setup
Run mode: Single Run, Sweeps and Corners
Tests:
  trisha_norgate_tri_1: trisha/norgate_tri/schematic, simulator spectre
